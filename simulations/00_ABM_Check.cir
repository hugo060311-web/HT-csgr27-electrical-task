* V5 ABM compatibility check; expected V(2)=6 V
V1 1 0 DC 12
R1 1 2 1k
G1 2 0 VALUE={MAX(V(2),0)/1000}
VVERSION 100 0 DC 5.05
.op
.end
